* AnalogCoderPro task 5: cascode_amplifier
* Upstream 05542af46020e5c37d5a7e3ca79da9f24626e1c9 / sample_design/p5/p5.py
* Native SPICE port; run using verification/run.py.
* Connectivity preserved; GND normalized to 0; sizing/bias supplied per case.
.include "model.inc"
.include "parameters.inc"
.temp 27
Vdd vdd 0 {vdd}
vin vin 0 DC {bin*vdd} AC 1 SIN({bin*vdd} 10u 1Meg)
cexternal vout 0 1f
rload vout vdd {r10000}
m1 drain_m1 vin 0 0 nmos W={wn50} L={ln50}
m2 vout vbias drain_m1 drain_m1 nmos W={wn50} L={ln50}
vvbias vbias 0 {b1*vdd}
.include "analysis.inc"
.end
