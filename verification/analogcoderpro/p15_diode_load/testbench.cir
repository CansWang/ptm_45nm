* AnalogCoderPro task 15: diode_load
* Upstream 05542af46020e5c37d5a7e3ca79da9f24626e1c9 / sample_design/p15/p15.py
* Native SPICE port; run using verification/run.py.
* Connectivity preserved; GND normalized to 0; sizing/bias supplied per case.
.include "model.inc"
.include "parameters.inc"
.temp 27
Vdd vdd 0 {vdd}
vin vin 0 DC {bin*vdd} AC 1 SIN({bin*vdd} 10u 1Meg)
cexternal vout 0 1f
m1 vout vin 0 0 nmos W={wn50} L={ln50}
m2 vout vout vdd vdd pmos W={wp50} L={lp50}
.include "analysis.inc"
.end
