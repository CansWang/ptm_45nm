* AnalogCoderPro task 7: cmos_inverter
* Upstream 05542af46020e5c37d5a7e3ca79da9f24626e1c9 / sample_design/p7/p7.py
* Native SPICE port; run using verification/run.py.
* Connectivity preserved; GND normalized to 0; sizing/bias supplied per case.
.include "model.inc"
.include "parameters.inc"
.temp 27
Vdd vdd 0 {vdd}
vin vin 0 PULSE(0 {vdd} 100p 20p 20p 480p 1n)
cexternal vout 0 1f
m_n vout vin 0 0 nmos W={wn10} L={ln10}
m_p vout vin vdd vdd pmos W={wp10} L={lp10}
.include "analysis.inc"
.end
